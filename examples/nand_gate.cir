CMOS NAND Gate
* 2-Input NAND Gate
M1 out a vdd vdd pmos W=20u L=1u
M2 out b vdd vdd pmos W=20u L=1u
M3 out a n1 0 nmos W=10u L=1u
M4 n1 b 0 0 nmos W=10u L=1u
VDD vdd 0 DC 5V
VA a 0 DC 2.5V
VB b 0 DC 2.5V
.end
